{
    name: "bitreversal_control",
    clock_primary: "clk_i",
    reset_primary: "rst_ni",
    bus_interfaces: [
        {
            protocol: "reg_iface",
            direction: "device"
        }
    ],
    regwidth: "32",
    registers: [

        {
            name: "DIN",
            desc: "Operando de entrada",
            fields: [
                {
                    bits: "31:0",
                    name: "DIN",
                    desc: "Operando de entrada.",
                    swaccess: "rw",
                    hwaccess: "hro",
                    resval: "0"
                }
            ]
        },

        {
            name: "START",
            desc: "Control de inicio de la operación",
            fields: [
                {
                    bits: "0",
                    name: "START",
                    desc: "Escribir 1 para iniciar la operación. Permanece en 1 hasta que el software escriba 0.",
                    swaccess: "rw",
                    hwaccess: "hro",
                    resval: "0"
                }
            ]
        },

        {
            name: "READ",
            desc: "Permite obtener dato resultado, por cada activacion",
            fields: [
                {
                    bits: "0",
                    name: "READ",
                    desc: "Escribir 1 para iniciar la operación, escribir 0 para parar",
                    swaccess: "rw",
                    hwaccess: "hro",
                    resval: "0"
                }
            ]
        },

	    {
            name: "WRITE",
            desc: "Permite encolar un dato en la FIFO, por cada activacion",
            fields: [
                {
                    bits: "0",
                    name: "WRITE",
                    desc: "Escribir 1 para iniciar la operación, escribir 0 para parar",
                    swaccess: "rw",
                    hwaccess: "hro",
                    resval: "0"
                }
            ]
        },

        {
            name: "DONE",
            desc: "Estado de la operación",
            fields: [
                {
                    bits: "0",
                    name: "DONE",
                    desc: "Se pone en 1 cuando el resultado está disponible. Se borra al leerlo o escribiendo 1.",
                    swaccess: "rw1c",
                    hwaccess: "hwo",
                    resval: "0"
                }
            ]
        },

        {
            name: "DOUT",
            desc: "Resultado de la operación",
            fields: [
                {
                    bits: "31:0",
                    name: "DOUT",
                    desc: "Resultado del cálculo (32 bits).",
                    swaccess: "ro",
                    hwaccess: "hwo"
                }
            ]
        }
    ]
}

